.option scale=1E-6
.param mc_mm_switch=0

.include "/home/aamreidd/sky130_project/skywater-pdk-libs-sky130_fd_pr/models/r+c/res_typical__cap_typical__lin.spice"
.include "/home/aamreidd/sky130_project/skywater-pdk-libs-sky130_fd_pr/models/r+c/res_typical__cap_typical.spice"
.include "/home/aamreidd/sky130_project/skywater-pdk-libs-sky130_fd_pr/models/corners/tt.spice"

.subckt invx1 A Y VPWR VGND
XMN Y A VGND VGND sky130_fd_pr__nfet_01v8 W=0.84 L=0.15
XMP Y A VPWR VPWR sky130_fd_pr__pfet_01v8 W=1.68 L=0.15
.ends invx1

.subckt invx2 A Y VPWR VGND
XMN Y A VGND VGND sky130_fd_pr__nfet_01v8 W=1.68 L=0.15
XMP Y A VPWR VPWR sky130_fd_pr__pfet_01v8 W=3.36 L=0.15
.ends invx2

.subckt invx4 A Y VPWR VGND
XMN Y A VGND VGND sky130_fd_pr__nfet_01v8 W=3.36 L=0.15
XMP Y A VPWR VPWR sky130_fd_pr__pfet_01v8 W=6.72 L=0.15
.ends invx4

.subckt invx8 A Y VPWR VGND
XMN Y A VGND VGND sky130_fd_pr__nfet_01v8 W=6.72 L=0.15
XMP Y A VPWR VPWR sky130_fd_pr__pfet_01v8 W=13.44 L=0.15
.ends invx8

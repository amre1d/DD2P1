.option scale=1E-6
.param mc_mm_switch=0

.include "/home/aamreidd/sky130_project/skywater-pdk-libs-sky130_fd_pr/models/r+c/res_typical__cap_typical__lin.spice"
.include "/home/aamreidd/sky130_project/skywater-pdk-libs-sky130_fd_pr/models/r+c/res_typical__cap_typical.spice"
.include "/home/aamreidd/sky130_project/skywater-pdk-libs-sky130_fd_pr/models/corners/tt.spice"

.subckt invx1 A Y VPWR VGND
XMN Y A VGND VGND sky130_fd_pr__nfet_01v8 W=0.84 L=0.15
XMP Y A VPWR VPWR sky130_fd_pr__pfet_01v8 W=1.68 L=0.15
.ends invx1

.subckt invx2 A Y VPWR VGND
XMN Y A VGND VGND sky130_fd_pr__nfet_01v8 W=1.68 L=0.15
XMP Y A VPWR VPWR sky130_fd_pr__pfet_01v8 W=3.36 L=0.15
.ends invx2

.subckt invx4 A Y VPWR VGND
XMN Y A VGND VGND sky130_fd_pr__nfet_01v8 W=3.36 L=0.15
XMP Y A VPWR VPWR sky130_fd_pr__pfet_01v8 W=6.72 L=0.15
.ends invx4

.subckt invx8 A Y VPWR VGND
XMN Y A VGND VGND sky130_fd_pr__nfet_01v8 W=6.72 L=0.15
XMP Y A VPWR VPWR sky130_fd_pr__pfet_01v8 W=13.44 L=0.15
.ends invx8

.subckt nand2x1 A B Y VPWR VGND
XMP1 Y A VPWR VPWR sky130_fd_pr__pfet_01v8 W=1.68 L=0.15
XMP2 Y B VPWR VPWR sky130_fd_pr__pfet_01v8 W=1.68 L=0.15
XMN1 Y A N1 VGND sky130_fd_pr__nfet_01v8 W=1.68 L=0.15
XMN2 N1 B VGND VGND sky130_fd_pr__nfet_01v8 W=1.68 L=0.15
.ends nand2x1

.subckt nand2x2 A B Y VPWR VGND
XMP1 Y A VPWR VPWR sky130_fd_pr__pfet_01v8 W=3.36 L=0.15
XMP2 Y B VPWR VPWR sky130_fd_pr__pfet_01v8 W=3.36 L=0.15
XMN1 Y A N1 VGND sky130_fd_pr__nfet_01v8 W=3.36 L=0.15
XMN2 N1 B VGND VGND sky130_fd_pr__nfet_01v8 W=3.36 L=0.15
.ends nand2x2

.subckt nand2x4 A B Y VPWR VGND
XMP1 Y A VPWR VPWR sky130_fd_pr__pfet_01v8 W=6.72 L=0.15
XMP2 Y B VPWR VPWR sky130_fd_pr__pfet_01v8 W=6.72 L=0.15
XMN1 Y A N1 VGND sky130_fd_pr__nfet_01v8 W=6.72 L=0.15
XMN2 N1 B VGND VGND sky130_fd_pr__nfet_01v8 W=6.72 L=0.15
.ends nand2x4

.subckt nor2x1 A B Y VPWR VGND
XMP1 Y A N2 VPWR sky130_fd_pr__pfet_01v8 W=3.36 L=0.15
XMP2 N2 B VPWR VPWR sky130_fd_pr__pfet_01v8 W=3.36 L=0.15
XMN1 Y A VGND VGND sky130_fd_pr__nfet_01v8 W=0.84 L=0.15
XMN2 Y B VGND VGND sky130_fd_pr__nfet_01v8 W=0.84 L=0.15
.ends nor2x1

.subckt nor2x2 A B Y VPWR VGND
XMP1 Y A N2 VPWR sky130_fd_pr__pfet_01v8 W=6.72 L=0.15
XMP2 N2 B VPWR VPWR sky130_fd_pr__pfet_01v8 W=6.72 L=0.15
XMN1 Y A VGND VGND sky130_fd_pr__nfet_01v8 W=1.68 L=0.15
XMN2 Y B VGND VGND sky130_fd_pr__nfet_01v8 W=1.68 L=0.15
.ends nor2x2

.subckt nor2x4 A B Y VPWR VGND
XMP1 Y A N2 VPWR sky130_fd_pr__pfet_01v8 W=13.44 L=0.15
XMP2 N2 B VPWR VPWR sky130_fd_pr__pfet_01v8 W=13.44 L=0.15
XMN1 Y A VGND VGND sky130_fd_pr__nfet_01v8 W=3.36 L=0.15
XMN2 Y B VGND VGND sky130_fd_pr__nfet_01v8 W=3.36 L=0.15
.ends nor2x4

.subckt maj3x1 A B C Y VPWR VGND
XAB1 N1 A VPWR VPWR sky130_fd_pr__pfet_01v8 W=3.36 L=0.15
XAB2 Y B N1 VPWR sky130_fd_pr__pfet_01v8 W=3.36 L=0.15
XAC1 N2 A VPWR VPWR sky130_fd_pr__pfet_01v8 W=3.36 L=0.15
XAC2 Y C N2 VPWR sky130_fd_pr__pfet_01v8 W=3.36 L=0.15
XBC1 N3 B VPWR VPWR sky130_fd_pr__pfet_01v8 W=3.36 L=0.15
XBC2 Y C N3 VPWR sky130_fd_pr__pfet_01v8 W=3.36 L=0.15
XABN1 Y A N4 VGND sky130_fd_pr__nfet_01v8 W=1.68 L=0.15
XABN2 N4 B VGND VGND sky130_fd_pr__nfet_01v8 W=1.68 L=0.15
XACN1 Y A N5 VGND sky130_fd_pr__nfet_01v8 W=1.68 L=0.15
XACN2 N5 C VGND VGND sky130_fd_pr__nfet_01v8 W=1.68 L=0.15
XBCN1 Y B N6 VGND sky130_fd_pr__nfet_01v8 W=1.68 L=0.15
XBCN2 N6 C VGND VGND sky130_fd_pr__nfet_01v8 W=1.68 L=0.15
.ends maj3x1

.subckt maj3x2 A B C Y VPWR VGND
XAB1 N1 A VPWR VPWR sky130_fd_pr__pfet_01v8 W=6.72 L=0.15
XAB2 Y B N1 VPWR sky130_fd_pr__pfet_01v8 W=6.72 L=0.15
XAC1 N2 A VPWR VPWR sky130_fd_pr__pfet_01v8 W=6.72 L=0.15
XAC2 Y C N2 VPWR sky130_fd_pr__pfet_01v8 W=6.72 L=0.15
XBC1 N3 B VPWR VPWR sky130_fd_pr__pfet_01v8 W=6.72 L=0.15
XBC2 Y C N3 VPWR sky130_fd_pr__pfet_01v8 W=6.72 L=0.15
XABN1 Y A N4 VGND sky130_fd_pr__nfet_01v8 W=3.36 L=0.15
XABN2 N4 B VGND VGND sky130_fd_pr__nfet_01v8 W=3.36 L=0.15
XACN1 Y A N5 VGND sky130_fd_pr__nfet_01v8 W=3.36 L=0.15
XACN2 N5 C VGND VGND sky130_fd_pr__nfet_01v8 W=3.36 L=0.15
XBCN1 Y B N6 VGND sky130_fd_pr__nfet_01v8 W=3.36 L=0.15
XBCN2 N6 C VGND VGND sky130_fd_pr__nfet_01v8 W=3.36 L=0.15
.ends maj3x2

.subckt maj3x4 A B C Y VPWR VGND
XAB1 N1 A VPWR VPWR sky130_fd_pr__pfet_01v8 W=13.44 L=0.15
XAB2 Y B N1 VPWR sky130_fd_pr__pfet_01v8 W=13.44 L=0.15
XAC1 N2 A VPWR VPWR sky130_fd_pr__pfet_01v8 W=13.44 L=0.15
XAC2 Y C N2 VPWR sky130_fd_pr__pfet_01v8 W=13.44 L=0.15
XBC1 N3 B VPWR VPWR sky130_fd_pr__pfet_01v8 W=13.44 L=0.15
XBC2 Y C N3 VPWR sky130_fd_pr__pfet_01v8 W=13.44 L=0.15
XABN1 Y A N4 VGND sky130_fd_pr__nfet_01v8 W=6.72 L=0.15
XABN2 N4 B VGND VGND sky130_fd_pr__nfet_01v8 W=6.72 L=0.15
XACN1 Y A N5 VGND sky130_fd_pr__nfet_01v8 W=6.72 L=0.15
XACN2 N5 C VGND VGND sky130_fd_pr__nfet_01v8 W=6.72 L=0.15
XBCN1 Y B N6 VGND sky130_fd_pr__nfet_01v8 W=6.72 L=0.15
XBCN2 N6 C VGND VGND sky130_fd_pr__nfet_01v8 W=6.72 L=0.15
.ends maj3x4

.include "/home/aamreidd/sky130_project/spice_lib/standard_cells.spice"

VDD VPWR 0 1.8
VIN A 0 PULSE(0 1.8 0.1n 0.01n 0.01n 1n 2n)
Cload Y 0 0.01p

XU1 A Y VPWR 0 invx1

.tran 0.001n 4n
.print tran v(A) v(Y)
.end

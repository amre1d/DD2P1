.include "/home/aamreidd/sky130_project/spice_lib/standard_cells.spice"

VDD VPWR 0 1.8
VA A 0 PULSE(0 1.8 0.1n 0.1225n 0.1225n 5n 10n)
VB B 0 DC 1.8
VC C 0 DC 0
Cload Y 0 0.0094p

XU1 A B C Y VPWR 0 maj3x2

.tran 0.001n 20n

.measure tran tphl trig v(A) val=0.9 rise=1 targ v(Y) val=0.9 fall=1
.measure tran tplh trig v(A) val=0.9 fall=1 targ v(Y) val=0.9 rise=1
.measure tran trise trig v(Y) val=0.36 rise=1 targ v(Y) val=1.44 rise=1
.measure tran tfall trig v(Y) val=1.44 fall=1 targ v(Y) val=0.36 fall=1

.end

* SKY130 model check
.lib "/home/aamreidd/sky130_project/skywater-pdk-libs-sky130_fd_pr/models/sky130.lib.spice" tt
.temp 25

Vdd vdd 0 1.8
Vin in 0 DC 0

M1 out in 0 0 sky130_fd_pr__nfet_01v8 L=0.15u W=1u
R1 vdd out 10k

.op
.end
